* Extracted by KLayout with the ICsprout55 LVS runset

.SUBCKT DFFQX1H7R CK D Q VDD|VNW VSS
M$1 VSS CK \$5 VSS NM1P2_SVT_LP L=0.06U W=0.2U AS=0.031P AD=0.022P PS=0.71U
+ PD=0.42U
M$2 \$11 D VSS VSS NM1P2_SVT_LP L=0.06U W=0.2U AS=0.022P AD=0.015P PS=0.42U
+ PD=0.35U
M$3 \$8 \$5 \$11 VSS NM1P2_SVT_LP L=0.06U W=0.2U AS=0.015P AD=0.025P PS=0.35U
+ PD=0.55U
M$4 \$12 \$3 \$8 VSS NM1P2_SVT_LP L=0.06U W=0.15U AS=0.025P AD=0.01425P
+ PS=0.55U PD=0.34U
M$5 \$12 \$9 VSS VSS NM1P2_SVT_LP L=0.06U W=0.15U AS=0.04025P AD=0.01425P
+ PS=0.67U PD=0.34U
M$6 \$9 \$8 VSS VSS NM1P2_SVT_LP L=0.06U W=0.2U AS=0.04025P AD=0.041P PS=0.67U
+ PD=0.81U
M$7 \$14 \$5 \$2 VSS NM1P2_SVT_LP L=0.06U W=0.15U AS=0.02185P AD=0.01125P
+ PS=0.46U PD=0.3U
M$8 VSS \$4 \$14 VSS NM1P2_SVT_LP L=0.06U W=0.15U AS=0.01125P AD=0.0255P
+ PS=0.3U PD=0.64U
M$9 \$3 \$5 VSS VSS NM1P2_SVT_LP L=0.06U W=0.2U AS=0.035625P AD=0.031P
+ PS=0.595U PD=0.71U
M$10 \$15 \$9 VSS VSS NM1P2_SVT_LP L=0.06U W=0.23U AS=0.035625P AD=0.017825P
+ PS=0.595U PD=0.385U
M$11 \$2 \$3 \$15 VSS NM1P2_SVT_LP L=0.06U W=0.23U AS=0.017825P AD=0.02185P
+ PS=0.385U PD=0.46U
M$12 VSS \$2 \$4 VSS NM1P2_SVT_LP L=0.06U W=0.2U AS=0.038P AD=0.0228P PS=0.78U
+ PD=0.445U
M$13 Q \$2 VSS VSS NM1P2_SVT_LP L=0.06U W=0.24U AS=0.0228P AD=0.0372P PS=0.445U
+ PD=0.79U
M$14 \$19 \$5 \$8 VDD|VNW PM1P2_SVT_LP L=0.06U W=0.15U AS=0.033725P AD=0.01125P
+ PS=0.63U PD=0.3U
M$15 \$19 \$9 VDD|VNW VDD|VNW PM1P2_SVT_LP L=0.06U W=0.15U AS=0.03865P
+ AD=0.01125P PS=0.745U PD=0.3U
M$16 \$9 \$8 VDD|VNW VDD|VNW PM1P2_SVT_LP L=0.06U W=0.28U AS=0.03865P
+ AD=0.0434P PS=0.745U PD=0.87U
M$17 VDD|VNW CK \$5 VDD|VNW PM1P2_SVT_LP L=0.06U W=0.28U AS=0.0434P AD=0.0353P
+ PS=0.87U PD=0.575U
M$18 \$18 D VDD|VNW VDD|VNW PM1P2_SVT_LP L=0.06U W=0.28U AS=0.0353P AD=0.021P
+ PS=0.575U PD=0.43U
M$19 \$8 \$3 \$18 VDD|VNW PM1P2_SVT_LP L=0.06U W=0.28U AS=0.021P AD=0.033725P
+ PS=0.43U PD=0.63U
M$20 \$3 \$5 VDD|VNW VDD|VNW PM1P2_SVT_LP L=0.06U W=0.28U AS=0.0282P AD=0.0434P
+ PS=0.51U PD=0.87U
M$21 \$20 \$9 VDD|VNW VDD|VNW PM1P2_SVT_LP L=0.06U W=0.32U AS=0.0282P AD=0.024P
+ PS=0.51U PD=0.47U
M$22 \$2 \$5 \$20 VDD|VNW PM1P2_SVT_LP L=0.06U W=0.32U AS=0.024P AD=0.035275P
+ PS=0.47U PD=0.66U
M$23 \$21 \$3 \$2 VDD|VNW PM1P2_SVT_LP L=0.06U W=0.15U AS=0.035275P AD=0.01275P
+ PS=0.66U PD=0.32U
M$24 VDD|VNW \$4 \$21 VDD|VNW PM1P2_SVT_LP L=0.06U W=0.15U AS=0.01275P
+ AD=0.02775P PS=0.32U PD=0.67U
M$25 VDD|VNW \$2 \$4 VDD|VNW PM1P2_SVT_LP L=0.06U W=0.28U AS=0.0434P
+ AD=0.03335P PS=0.87U PD=0.545U
M$26 Q \$2 VDD|VNW VDD|VNW PM1P2_SVT_LP L=0.06U W=0.34U AS=0.03335P AD=0.0527P
+ PS=0.545U PD=0.99U
.ENDS DFFQX1H7R
