* Extracted by KLayout with the ICsprout55 LVS runset

.SUBCKT TINVX1H7R A OE VDD|VNW VSS Y
M$1 VSS OE \$2 VSS NM1P2_SVT_LP L=0.06U W=0.15U AS=0.02325P AD=0.018525P
+ PS=0.61U PD=0.425U
M$2 \$8 A VSS VSS NM1P2_SVT_LP L=0.06U W=0.21U AS=0.018525P AD=0.01575P
+ PS=0.425U PD=0.36U
M$3 Y OE \$8 VSS NM1P2_SVT_LP L=0.06U W=0.21U AS=0.01575P AD=0.03255P PS=0.36U
+ PD=0.73U
M$4 \$2 OE VDD|VNW VDD|VNW PM1P2_SVT_LP L=0.06U W=0.19U AS=0.0247P AD=0.02945P
+ PS=0.49U PD=0.69U
M$5 \$9 A VDD|VNW VDD|VNW PM1P2_SVT_LP L=0.06U W=0.27U AS=0.0247P AD=0.02295P
+ PS=0.49U PD=0.44U
M$6 Y \$2 \$9 VDD|VNW PM1P2_SVT_LP L=0.06U W=0.27U AS=0.02295P AD=0.07155P
+ PS=0.44U PD=1.07U
.ENDS TINVX1H7R
