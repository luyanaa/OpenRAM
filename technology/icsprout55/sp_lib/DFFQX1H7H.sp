* DFFQX1H7H imported from ics55_LLSC_H7CH.cdl by import_stdcells.py
* Flattened; port order D Q CK VDD VSS
.SUBCKT DFFQX1H7H D Q CK VDD VSS
MXXI14_MN0 net33 net24 XXI14/net18 VSS nm1p2_hvt_lp W=0.15u L=0.06u M=1
MXXI14_MN1 XXI14/net18 net46 VSS VSS nm1p2_hvt_lp W=0.15u L=0.06u M=1
MXXI14_MP1 XXI14/net024 net46 VDD VDD pm1p2_hvt_lp W=0.15u L=0.06u M=1
MXXI14_MP0 net33 net32 XXI14/net024 VDD pm1p2_hvt_lp W=0.15u L=0.06u M=1
MXXI6_MN0 net33 net32 XXI6/net18 VSS nm1p2_hvt_lp W=0.2u L=0.06u M=1
MXXI6_MN1 XXI6/net18 D VSS VSS nm1p2_hvt_lp W=0.2u L=0.06u M=1
MXXI6_MP1 XXI6/net024 D VDD VDD pm1p2_hvt_lp W=0.28u L=0.06u M=1
MXXI6_MP0 net33 net24 XXI6/net024 VDD pm1p2_hvt_lp W=0.28u L=0.06u M=1
MXXI9_MN0 net25 net24 XXI9/net18 VSS nm1p2_hvt_lp W=0.23u L=0.06u M=1
MXXI9_MN1 XXI9/net18 net46 VSS VSS nm1p2_hvt_lp W=0.23u L=0.06u M=1
MXXI9_MP1 XXI9/net024 net46 VDD VDD pm1p2_hvt_lp W=0.32u L=0.06u M=1
MXXI9_MP0 net25 net32 XXI9/net024 VDD pm1p2_hvt_lp W=0.32u L=0.06u M=1
MXXI15_MN0 net25 net32 XXI15/net18 VSS nm1p2_hvt_lp W=0.15u L=0.06u M=1
MXXI15_MN1 XXI15/net18 net9 VSS VSS nm1p2_hvt_lp W=0.15u L=0.06u M=1
MXXI15_MP1 XXI15/net024 net9 VDD VDD pm1p2_hvt_lp W=0.15u L=0.06u M=1
MXXI15_MP0 net25 net24 XXI15/net024 VDD pm1p2_hvt_lp W=0.15u L=0.06u M=1
MXXI7_MN0 net46 net33 VSS VSS nm1p2_hvt_lp W=0.2u L=0.06u M=1
MXXI7_MP0 net46 net33 VDD VDD pm1p2_hvt_lp W=0.28u L=0.06u M=1
MXXI13_MN0 net24 net32 VSS VSS nm1p2_hvt_lp W=0.2u L=0.06u M=1
MXXI13_MP0 net24 net32 VDD VDD pm1p2_hvt_lp W=0.28u L=0.06u M=1
MXXI12_MN0 Q net25 VSS VSS nm1p2_hvt_lp W=0.24u L=0.06u M=1
MXXI12_MP0 Q net25 VDD VDD pm1p2_hvt_lp W=0.34u L=0.06u M=1
MXXI10_MN0 net9 net25 VSS VSS nm1p2_hvt_lp W=0.2u L=0.06u M=1
MXXI10_MP0 net9 net25 VDD VDD pm1p2_hvt_lp W=0.28u L=0.06u M=1
MXXI4_MN0 net32 CK VSS VSS nm1p2_hvt_lp W=0.2u L=0.06u M=1
MXXI4_MP0 net32 CK VDD VDD pm1p2_hvt_lp W=0.28u L=0.06u M=1
.ENDS DFFQX1H7H
