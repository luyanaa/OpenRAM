* ICsprout55 H7CR INVX1 hard-cell wrapper for OpenRAM.
.SUBCKT INVX1H7R A Y VDD VSS
MMN0 Y A VSS VSS nm1p2_svt_lp W=210n L=60n m=1
MMP0 Y A VDD VDD pm1p2_svt_lp W=270n L=60n m=1
.ENDS INVX1H7R
